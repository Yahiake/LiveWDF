* LiveWDF netlist exported by SpiceExport (core)
.title LiveWDF
* Engine integrates with trapezoidal at 48000 Hz
.options method=gear maxord=2 reltol=1e-4 abstol=1e-9 vntol=1e-5 chgtol=1e-12 trtol=7
R_HP_SW_ENABLE_A n1 in 0.01
R_HP_SW_ENABLE_B n1 n2 1000000000
R_HP_R_CUT_0_0 n21 0 58946.275219220501
R_HP_R_CUT_0_1 n17 0 33862.753849339431
R_HP_R_CUT_0_2 n18 0 19409.139401450651
R_HP_R_CUT_0_3 n14 0 10610.32953945969
R_HP_R_CUT_0_4 n13 0 5894.6275219220497
R_HP_SW_CUT_0_2_A n23 n21 0.01
R_HP_SW_CUT_0_2_B n23 n17 1000000000
R_HP_SW_CUT_0_3_A n24 n23 0.01
R_HP_SW_CUT_0_3_B n24 n18 1000000000
R_HP_SW_CUT_0_4_A n25 n24 0.01
R_HP_SW_CUT_0_4_B n25 n14 1000000000
R_HP_SW_CUT_0_5_A n8 n25 0.01
R_HP_SW_CUT_0_5_B n8 n13 1000000000
R_HP_R_CUT_1_0 n37 n2 29473.13760961025
R_HP_R_CUT_1_1 n33 n2 16931.376924669716
R_HP_R_CUT_1_2 n34 n2 9704.5697007253257
R_HP_R_CUT_1_3 n31 n2 5305.1647697298449
R_HP_R_CUT_1_4 n29 n2 2947.3137609610249
R_HP_SW_CUT_1_2_A n39 n37 0.01
R_HP_SW_CUT_1_2_B n39 n33 1000000000
R_HP_SW_CUT_1_3_A n40 n39 0.01
R_HP_SW_CUT_1_3_B n40 n34 1000000000
R_HP_SW_CUT_1_4_A n41 n40 0.01
R_HP_SW_CUT_1_4_B n41 n31 1000000000
R_HP_SW_CUT_1_5_A n9 n41 0.01
R_HP_SW_CUT_1_5_B n9 n29 1000000000
R_HP_R_CUT_2_0 n53 0 117892.550438441
R_HP_R_CUT_2_1 n49 0 67725.507698678863
R_HP_R_CUT_2_2 n50 0 38818.278802901303
R_HP_R_CUT_2_3 n47 0 21220.65907891938
R_HP_R_CUT_2_4 n45 0 11789.255043844099
R_HP_SW_CUT_2_2_A n55 n53 0.01
R_HP_SW_CUT_2_2_B n55 n49 1000000000
R_HP_SW_CUT_2_3_A n56 n55 0.01
R_HP_SW_CUT_2_3_B n56 n50 1000000000
R_HP_SW_CUT_2_4_A n57 n56 0.01
R_HP_SW_CUT_2_4_B n57 n47 1000000000
R_HP_SW_CUT_2_5_A n10 n57 0.01
R_HP_SW_CUT_2_5_B n10 n45 1000000000
R_LP_SW_ENABLE_A n7 n1 0.01
R_LP_SW_ENABLE_B n7 n4 1000000000
R_LP_R_CUT_0_0 n22 n11 8841.9412828830755
R_LP_R_CUT_0_1 n19 n11 13262.911924324611
R_LP_R_CUT_0_2 n15 n11 19409.139401450651
R_LP_R_CUT_0_3 n20 n11 28420.525552124167
R_LP_R_CUT_0_4 n16 n11 40808.95976715265
R_LP_SW_CUT_0_2_A n26 n22 0.01
R_LP_SW_CUT_0_2_B n26 n19 1000000000
R_LP_SW_CUT_0_3_A n27 n26 0.01
R_LP_SW_CUT_0_3_B n27 n15 1000000000
R_LP_SW_CUT_0_4_A n28 n27 0.01
R_LP_SW_CUT_0_4_B n28 n20 1000000000
R_LP_SW_CUT_0_5_A n1 n28 0.01
R_LP_SW_CUT_0_5_B n1 n16 1000000000
R_LP_R_CUT_1_0 n38 n3 8841.9412828830755
R_LP_R_CUT_1_1 n35 n3 13262.911924324611
R_LP_R_CUT_1_2 n36 n3 19409.139401450651
R_LP_R_CUT_1_3 n32 n3 28420.525552124167
R_LP_R_CUT_1_4 n30 n3 40808.95976715265
R_LP_SW_CUT_1_2_A n42 n38 0.01
R_LP_SW_CUT_1_2_B n42 n35 1000000000
R_LP_SW_CUT_1_3_A n43 n42 0.01
R_LP_SW_CUT_1_3_B n43 n36 1000000000
R_LP_SW_CUT_1_4_A n44 n43 0.01
R_LP_SW_CUT_1_4_B n44 n32 1000000000
R_LP_SW_CUT_1_5_A n6 n44 0.01
R_LP_SW_CUT_1_5_B n6 n30 1000000000
R_LP_R_CUT_2_0 n54 n12 8841.9412828830755
R_LP_R_CUT_2_1 n51 n12 13262.911924324611
R_LP_R_CUT_2_2 n52 n12 19409.139401450651
R_LP_R_CUT_2_3 n48 n12 28420.525552124167
R_LP_R_CUT_2_4 n46 n12 40808.95976715265
R_LP_SW_CUT_2_2_A n58 n54 0.01
R_LP_SW_CUT_2_2_B n58 n51 1000000000
R_LP_SW_CUT_2_3_A n59 n58 0.01
R_LP_SW_CUT_2_3_B n59 n52 1000000000
R_LP_SW_CUT_2_4_A n60 n59 0.01
R_LP_SW_CUT_2_4_B n60 n48 1000000000
R_LP_SW_CUT_2_5_A n3 n60 0.01
R_LP_SW_CUT_2_5_B n3 n46 1000000000
R_A6_R_IN n7 n79 15000
R_A6_R_SUP n63 n64 47
R_A6_R1 n64 n75 22000
R_A6_R2 n75 0 12000
R_A6_R3 n75 n85 47000
R_A6_R4 n87 0 2700
R_A6_R6 n64 n81 47000
R_A6_R10 n94 0 560
R_A6_R9 n64 n80 560
R_A6_R8 n71 n94 2200
R_A6_R11 n93 0 150
R_A6_R12 n64 n74 10000
R_A6_R13 n101 0 550
R_A6_R5 n69 n70 7500
R_A6_R14 n70 n71 7500
R_A6_R_LOAD n82 0 10000
R_A6_R_EDGE_A n7 n91 620
R_A6_R_EDGE_B n82 n92 620
R_A6_RV_GAIN_1 n100 n89 5000
R_A6_RV_GAIN_2 n89 n95 5000
R_A6_R_BELL n91 n99 4700
R_A6_SW_BELL_A n91 n97 0.01
R_A6_SW_BELL_B n91 n99 1000000000
R_R_A6_SW_BELL_open n97 0 1000000000
R_A6_R_OFF_A n100 n111 10000000
R_A6_R_OFF_B n95 n151 10000000
R_A6_R_OFF_C n92 n170 10000000
R_A6_R_W n89 n79 0.01
R_A6_SW_A_2_A n112 n111 0.01
R_A6_SW_A_2_B n112 n105 1000000000
R_A6_SW_A_3_A n113 n112 0.01
R_A6_SW_A_3_B n113 n106 1000000000
R_A6_SW_A_4_A n114 n113 0.01
R_A6_SW_A_4_B n114 n107 1000000000
R_A6_SW_A_5_A n115 n114 0.01
R_A6_SW_A_5_B n115 n108 1000000000
R_A6_SW_A_6_A n100 n115 0.01
R_A6_SW_A_6_B n100 n109 1000000000
R_A6_SW_B_2_A n152 n151 0.01
R_A6_SW_B_2_B n152 n136 1000000000
R_A6_SW_B_3_A n153 n152 0.01
R_A6_SW_B_3_B n153 n137 1000000000
R_A6_SW_B_4_A n154 n153 0.01
R_A6_SW_B_4_B n154 n138 1000000000
R_A6_SW_B_5_A n155 n154 0.01
R_A6_SW_B_5_B n155 n139 1000000000
R_A6_SW_B_6_A n95 n155 0.01
R_A6_SW_B_6_B n95 n140 1000000000
R_A6_SW_C_2_A n171 n170 0.01
R_A6_SW_C_2_B n171 n165 1000000000
R_A6_SW_C_3_A n172 n171 0.01
R_A6_SW_C_3_B n172 n166 1000000000
R_A6_SW_C_4_A n173 n172 0.01
R_A6_SW_C_4_B n173 n167 1000000000
R_A6_SW_C_5_A n174 n173 0.01
R_A6_SW_C_5_B n174 n168 1000000000
R_A6_SW_C_6_A n92 n174 0.01
R_A6_SW_C_6_B n92 n169 1000000000
R_A4_R_PRES_IN n82 n76 30000
R_A4_R_SUP n61 n62 47
R_A4_R1 n62 n73 22000
R_A4_R2 n73 0 12000
R_A4_R3 n73 n83 47000
R_A4_R4 n86 0 2700
R_A4_R6 n62 n78 47000
R_A4_R10 n90 0 560
R_A4_R9 n62 n77 560
R_A4_R8 n68 n90 2200
R_A4_R11 n88 0 150
R_A4_R12 n62 n72 10000
R_A4_R13 n96 0 550
R_A4_R5 n67 n66 7500
R_A4_R14 n66 n68 7500
R_A4_R_GAIN n65 0 3600
R_A4_R_LOAD n84 0 10000
R_A4_RV_PRES_1 n82 n98 5000
R_A4_RV_PRES_2 n98 n84 5000
R_A4_R_SER n102 n103 6800
R_A4_R_SER2 n103 n76 4300
R_A4_SW_Q_A n102 n104 0.01
R_A4_SW_Q_B n102 n103 1000000000
R_R_A4_SW_Q_open n104 0 1000000000
R_A4_R_FREQ_OFF n110 0 10000000
R_R_A4_L_0 n116 n126 105
R_R_A4_L_1 n117 n127 105
R_A4_R_BLEED_1 n141 n142 4700000
R_R_A4_L_2 n118 n128 105
R_A4_R_BLEED_2 n142 n143 4700000
R_R_A4_L_3 n119 n129 57
R_A4_R_BLEED_3 n143 n144 4700000
R_R_A4_L_4 n120 n130 57
R_A4_R_BLEED_4 n144 n145 4700000
R_R_A4_L_5 n121 n131 57
R_A4_R_BLEED_5 n145 n146 4700000
R_R_A4_L_6 n122 n132 46
R_A4_R_BLEED_6 n146 n147 4700000
R_R_A4_L_7 n123 n133 46
R_A4_R_BLEED_7 n147 n148 4700000
R_R_A4_L_8 n124 n134 24
R_A4_R_BLEED_8 n148 n149 4700000
R_R_A4_L_9 n125 n135 24
R_A4_R_BLEED_9 n149 n150 4700000
R_A4_SW_PRES_2_A n156 n110 0.01
R_A4_SW_PRES_2_B n156 n141 1000000000
R_A4_SW_PRES_3_A n157 n156 0.01
R_A4_SW_PRES_3_B n157 n142 1000000000
R_A4_SW_PRES_4_A n158 n157 0.01
R_A4_SW_PRES_4_B n158 n143 1000000000
R_A4_SW_PRES_5_A n159 n158 0.01
R_A4_SW_PRES_5_B n159 n144 1000000000
R_A4_SW_PRES_6_A n160 n159 0.01
R_A4_SW_PRES_6_B n160 n145 1000000000
R_A4_SW_PRES_7_A n161 n160 0.01
R_A4_SW_PRES_7_B n161 n146 1000000000
R_A4_SW_PRES_8_A n162 n161 0.01
R_A4_SW_PRES_8_B n162 n147 1000000000
R_A4_SW_PRES_9_A n163 n162 0.01
R_A4_SW_PRES_9_B n163 n148 1000000000
R_A4_SW_PRES_10_A n164 n163 0.01
R_A4_SW_PRES_10_B n164 n149 1000000000
R_A4_SW_PRES_11_A n98 n164 0.01
R_A4_SW_PRES_11_B n98 n150 1000000000
R_A5_R_PRES_IN n84 n190 30000
R_A5_R_SUP n175 n176 47
R_A5_R1 n176 n187 22000
R_A5_R2 n187 0 12000
R_A5_R3 n187 n197 47000
R_A5_R4 n198 0 2700
R_A5_R6 n176 n192 47000
R_A5_R10 n204 0 560
R_A5_R9 n176 n191 560
R_A5_R8 n182 n204 2200
R_A5_R11 n203 0 150
R_A5_R12 n176 n186 10000
R_A5_R13 n210 0 550
R_A5_R5 n181 n180 7500
R_A5_R14 n180 n182 7500
R_A5_R_GAIN n179 0 3600
R_A5_R_LOAD n196 0 10000
R_A5_RV_PRES_1 n84 n211 5000
R_A5_RV_PRES_2 n211 n196 5000
R_A5_R_SER n215 n190 6800
R_A5_SW_Q_A n215 n216 0.01
R_A5_SW_Q_B n215 n190 1000000000
R_R_A5_SW_Q_open n216 0 1000000000
R_A5_R_FREQ_OFF n223 0 10000000
R_R_A5_L_0 n228 n238 4336
R_R_A5_L_1 n229 n239 4336
R_A5_R_BLEED_1 n253 n254 4700000
R_R_A5_L_2 n230 n240 4336
R_A5_R_BLEED_2 n254 n255 4700000
R_R_A5_L_3 n231 n241 4104
R_A5_R_BLEED_3 n255 n256 4700000
R_R_A5_L_4 n232 n242 4104
R_A5_R_BLEED_4 n256 n257 4700000
R_R_A5_L_5 n233 n243 4104
R_A5_R_BLEED_5 n257 n258 4700000
R_R_A5_L_6 n234 n244 3911
R_A5_R_BLEED_6 n258 n259 4700000
R_R_A5_L_7 n235 n245 3911
R_A5_R_BLEED_7 n259 n260 4700000
R_R_A5_L_8 n236 n246 4100
R_A5_R_BLEED_8 n260 n261 4700000
R_R_A5_L_9 n237 n247 4100
R_A5_R_BLEED_9 n261 n262 4700000
R_A5_SW_PRES_2_A n267 n223 0.01
R_A5_SW_PRES_2_B n267 n253 1000000000
R_A5_SW_PRES_3_A n268 n267 0.01
R_A5_SW_PRES_3_B n268 n254 1000000000
R_A5_SW_PRES_4_A n269 n268 0.01
R_A5_SW_PRES_4_B n269 n255 1000000000
R_A5_SW_PRES_5_A n270 n269 0.01
R_A5_SW_PRES_5_B n270 n256 1000000000
R_A5_SW_PRES_6_A n271 n270 0.01
R_A5_SW_PRES_6_B n271 n257 1000000000
R_A5_SW_PRES_7_A n272 n271 0.01
R_A5_SW_PRES_7_B n272 n258 1000000000
R_A5_SW_PRES_8_A n273 n272 0.01
R_A5_SW_PRES_8_B n273 n259 1000000000
R_A5_SW_PRES_9_A n274 n273 0.01
R_A5_SW_PRES_9_B n274 n260 1000000000
R_A5_SW_PRES_10_A n275 n274 0.01
R_A5_SW_PRES_10_B n275 n261 1000000000
R_A5_SW_PRES_11_A n211 n275 0.01
R_A5_SW_PRES_11_B n211 n262 1000000000
R_A7_R_IN n196 n193 15000
R_A7_R_SUP n177 n178 47
R_A7_R1 n178 n189 22000
R_A7_R2 n189 0 12000
R_A7_R3 n189 n199 47000
R_A7_R4 n201 0 2700
R_A7_R6 n178 n195 47000
R_A7_R10 n209 0 560
R_A7_R9 n178 n194 560
R_A7_R8 n185 n209 2200
R_A7_R11 n208 0 150
R_A7_R12 n178 n188 10000
R_A7_R13 n214 0 550
R_A7_R5 n183 n184 7500
R_A7_R14 n184 n185 7500
R_A7_R_LOAD n200 0 10000
R_A7_R_EDGE_A n196 n207 620
R_A7_R_EDGE_B n200 n202 620
R_A7_RV_GAIN_1 n212 n205 1999.9999999999995
R_A7_RV_GAIN_2 n205 n213 8000
R_A7_R_BLEED n193 n205 4700000
R_A7_SW_BELL_A n193 n205 0.01
R_A7_SW_BELL_B n193 n206 1000000000
R_R_A7_SW_BELL_open n206 0 1000000000
R_A7_R_MID_REF n217 n207 10000000
R_A7_SW_A_2_A n224 n212 1000000000
R_A7_SW_A_2_B n224 n218 0.01
R_A7_SW_A_3_A n225 n224 0.01
R_A7_SW_A_3_B n225 n219 1000000000
R_A7_SW_A_4_A n226 n225 0.01
R_A7_SW_A_4_B n226 n220 1000000000
R_A7_SW_A_5_A n227 n226 0.01
R_A7_SW_A_5_B n227 n221 1000000000
R_A7_SW_A_6_A n205 n227 0.01
R_A7_SW_A_6_B n205 n222 1000000000
R_A7_SW_B_2_A n263 n213 1000000000
R_A7_SW_B_2_B n263 n248 0.01
R_A7_SW_B_3_A n264 n263 0.01
R_A7_SW_B_3_B n264 n249 1000000000
R_A7_SW_B_4_A n265 n264 0.01
R_A7_SW_B_4_B n265 n250 1000000000
R_A7_SW_B_5_A n266 n265 0.01
R_A7_SW_B_5_B n266 n251 1000000000
R_A7_SW_B_6_A n205 n266 0.01
R_A7_SW_B_6_B n205 n252 1000000000
R_A7_SW_C_2_A n281 n217 1000000000
R_A7_SW_C_2_B n281 n276 0.01
R_A7_SW_C_3_A n282 n281 0.01
R_A7_SW_C_3_B n282 n277 1000000000
R_A7_SW_C_4_A n283 n282 0.01
R_A7_SW_C_4_B n283 n278 1000000000
R_A7_SW_C_5_A n284 n283 0.01
R_A7_SW_C_5_B n284 n279 1000000000
R_A7_SW_C_6_A n205 n284 0.01
R_A7_SW_C_6_B n205 n280 1000000000
R_A7_R_LINK_A n212 n207 0.01
R_A7_R_LINK_B n213 n202 0.01
R_SW_BYPASS_A out n200 0.01
R_SW_BYPASS_B out in 1000000000
C_HP_C1 in n8 9.9999999999999995e-08
C_HP_C2 n5 n9 9.9999999999999995e-08
C_HP_C3 n9 n10 9.9999999999999995e-08
C_LP_C1 n11 0 1.0000000000000001e-09
C_LP_C2 n3 n4 2.0000000000000001e-09
C_LP_C3 n12 0 5.0000000000000003e-10
C_A6_C_SUP n64 0 0.00010001
C_A6_C2 n75 0 2.1999999999999999e-05
C_A6_C_IN n79 n69 2.1999999999999999e-05
C_A6_C3 n87 n81 1e-10
C_A6_C_OUT n71 n82 0.00014999999999999999
C_A6_SW_A_C1 n105 n91 1.5000000000000002e-08
C_A6_SW_A_C2 n106 n91 2.5000000000000002e-08
C_A6_SW_A_C3 n107 n91 3.5000000000000002e-08
C_A6_SW_A_C4 n108 n91 5.0000000000000004e-08
C_A6_SW_A_C5 n109 n91 7.2000000000000009e-08
C_A6_SW_B_C1 n136 n92 1.5000000000000002e-08
C_A6_SW_B_C2 n137 n92 2.5000000000000002e-08
C_A6_SW_B_C3 n138 n92 3.5000000000000002e-08
C_A6_SW_B_C4 n139 n92 5.0000000000000004e-08
C_A6_SW_B_C5 n140 n92 7.2000000000000009e-08
C_A6_SW_C_C1 n165 n99 1.8e-09
C_A6_SW_C_C2 n166 n99 2.4800000000000001e-09
C_A6_SW_C_C3 n167 n99 3.48e-09
C_A6_SW_C_C4 n168 n99 4.9799999999999998e-09
C_A6_SW_C_C5 n169 n99 7.6799999999999999e-09
C_A4_C_SUP n62 0 0.00010001
C_A4_C2 n73 0 2.1999999999999999e-05
C_A4_C_IN n76 n67 2.1999999999999999e-05
C_A4_C3 n86 n78 1e-10
C_A4_C_GAIN n66 n65 2.1999999999999999e-05
C_A4_C_OUT n68 n84 0.00014999999999999999
C_A4_C_0 n126 n141 1.5000000000000002e-08
C_A4_C_1 n127 n142 1e-08
C_A4_C_2 n128 n143 6.8000000000000005e-09
C_A4_C_3 n129 n144 6.8000000000000005e-09
C_A4_C_4 n130 n145 4.7000000000000007e-09
C_A4_C_5 n131 n146 3.3000000000000002e-09
C_A4_C_6 n132 n147 3.9000000000000002e-09
C_A4_C_7 n133 n148 2.7000000000000002e-09
C_A4_C_8 n134 n149 2.7000000000000002e-09
C_A4_C_9 n135 n150 1.8000000000000002e-09
C_A5_C_SUP n176 0 0.00010001
C_A5_C2 n187 0 2.1999999999999999e-05
C_A5_C_IN n190 n181 2.1999999999999999e-05
C_A5_C3 n198 n192 1e-10
C_A5_C_GAIN n180 n179 2.1999999999999999e-05
C_A5_C_OUT n182 n196 0.00014999999999999999
C_A5_C_0 n238 n253 1.0000000000000001e-07
C_A5_C_1 n239 n254 6.8e-08
C_A5_C_2 n240 n255 4.7000000000000004e-08
C_A5_C_3 n241 n256 4.7000000000000004e-08
C_A5_C_4 n242 n257 3.3000000000000004e-08
C_A5_C_5 n243 n258 2.2000000000000002e-08
C_A5_C_6 n244 n259 2.6700000000000001e-08
C_A5_C_7 n245 n260 1.77e-08
C_A5_C_8 n246 n261 1.8300000000000002e-08
C_A5_C_9 n247 n262 1.22e-08
C_A7_C_SUP n178 0 0.00010001
C_A7_C2 n189 0 2.1999999999999999e-05
C_A7_C_IN n193 n183 2.1999999999999999e-05
C_A7_C3 n201 n195 1e-10
C_A7_C_OUT n185 n200 0.00014999999999999999
C_A7_SW_A_C1 n218 n207 6.8e-08
C_A7_SW_A_C2 n219 n207 1.2500000000000002e-07
C_A7_SW_A_C3 n220 n207 2.2500000000000002e-07
C_A7_SW_A_C4 n221 n207 4.4500000000000003e-07
C_A7_SW_A_C5 n222 n207 7.750000000000001e-07
C_A7_SW_B_C1 n248 n202 6.8e-08
C_A7_SW_B_C2 n249 n202 1.2500000000000002e-07
C_A7_SW_B_C3 n250 n202 2.2500000000000002e-07
C_A7_SW_B_C4 n251 n202 4.4500000000000003e-07
C_A7_SW_B_C5 n252 n202 7.750000000000001e-07
C_A7_SW_C_C1 n276 n193 3.3000000000000004e-08
C_A7_SW_C_C2 n277 n193 2.53e-07
C_A7_SW_C_C3 n278 n193 7.23e-07
C_A7_SW_C_C4 n279 n193 1.4030000000000002e-06
C_A7_SW_C_C5 n280 n193 2.903e-06
L_A4_L_0 n102 n116 0.76700000000000002
L_A4_L_1 n102 n117 0.76700000000000002
L_A4_L_2 n102 n118 0.76700000000000002
L_A4_L_3 n102 n119 0.504
L_A4_L_4 n102 n120 0.504
L_A4_L_5 n102 n121 0.504
L_A4_L_6 n102 n122 0.29599999999999999
L_A4_L_7 n102 n123 0.29599999999999999
L_A4_L_8 n102 n124 0.20499999999999999
L_A4_L_9 n102 n125 0.20499999999999999
L_A5_L_0 n215 n228 5.1100000000000003
L_A5_L_1 n215 n229 5.1100000000000003
L_A5_L_2 n215 n230 5.1100000000000003
L_A5_L_3 n215 n231 3.5600000000000001
L_A5_L_4 n215 n232 3.5600000000000001
L_A5_L_5 n215 n233 3.5600000000000001
L_A5_L_6 n215 n234 2.0600000000000001
L_A5_L_7 n215 n235 2.0600000000000001
L_A5_L_8 n215 n236 1.4299999999999999
L_A5_L_9 n215 n237 1.4299999999999999
V_IN1 in 0 DC 0 AC 1
V_A6_BPLUS n63 0 DC 24
V_A4_BPLUS n61 0 DC 24
V_A5_BPLUS n175 0 DC 24
V_A7_BPLUS n177 0 DC 24
E_HP_A x_HP_A_out 0 n8 n5 100000
R_HP_A_ro x_HP_A_out n5 0.10000000000000001
E_HP_B x_HP_B_out 0 n10 n2 100000
R_HP_B_ro x_HP_B_out n2 0.10000000000000001
E_LP_A x_LP_A_out 0 n11 n6 100000
R_LP_A_ro x_LP_A_out n6 0.10000000000000001
E_LP_B x_LP_B_out 0 n12 n4 100000
R_LP_B_ro x_LP_B_out n4 0.10000000000000001
.model Dmod_A6_D3 D(Is=9.9999999999999995e-07 N=1 RS=5)
D_A6_D3 n71 n80 Dmod_A6_D3
Rp_A6_D3 n71 n80 1000000
.model Dmod_A6_D1 D(Is=4.3519999999999999e-09 N=1.9050000000000002 RS=0.56000000000000005)
D_A6_D1 n74 n101 Dmod_A6_D1
Rp_A6_D1 n74 n101 1000000
.model Dmod_A6_D2 D(Is=4.3519999999999999e-09 N=1.9050000000000002 RS=0.56000000000000005)
D_A6_D2 n93 n85 Dmod_A6_D2
Rp_A6_D2 n93 n85 1000000
.model Dmod_A4_D3 D(Is=9.9999999999999995e-07 N=1 RS=5)
D_A4_D3 n68 n77 Dmod_A4_D3
Rp_A4_D3 n68 n77 1000000
.model Dmod_A4_D1 D(Is=4.3519999999999999e-09 N=1.9050000000000002 RS=0.56000000000000005)
D_A4_D1 n72 n96 Dmod_A4_D1
Rp_A4_D1 n72 n96 1000000
.model Dmod_A4_D2 D(Is=4.3519999999999999e-09 N=1.9050000000000002 RS=0.56000000000000005)
D_A4_D2 n88 n83 Dmod_A4_D2
Rp_A4_D2 n88 n83 1000000
.model Dmod_A5_D3 D(Is=9.9999999999999995e-07 N=1 RS=5)
D_A5_D3 n182 n191 Dmod_A5_D3
Rp_A5_D3 n182 n191 1000000
.model Dmod_A5_D1 D(Is=4.3519999999999999e-09 N=1.9050000000000002 RS=0.56000000000000005)
D_A5_D1 n186 n210 Dmod_A5_D1
Rp_A5_D1 n186 n210 1000000
.model Dmod_A5_D2 D(Is=4.3519999999999999e-09 N=1.9050000000000002 RS=0.56000000000000005)
D_A5_D2 n203 n197 Dmod_A5_D2
Rp_A5_D2 n203 n197 1000000
.model Dmod_A7_D3 D(Is=9.9999999999999995e-07 N=1 RS=5)
D_A7_D3 n185 n194 Dmod_A7_D3
Rp_A7_D3 n185 n194 1000000
.model Dmod_A7_D1 D(Is=4.3519999999999999e-09 N=1.9050000000000002 RS=0.56000000000000005)
D_A7_D1 n188 n214 Dmod_A7_D1
Rp_A7_D1 n188 n214 1000000
.model Dmod_A7_D2 D(Is=4.3519999999999999e-09 N=1.9050000000000002 RS=0.56000000000000005)
D_A7_D2 n208 n199 Dmod_A7_D2
Rp_A7_D2 n208 n199 1000000
.model Qmod_A6_TR1 PNP(IS=3.8299999999999998e-14 BF=344.39999999999998 BR=14.84 NF=1.008 NR=1.0049999999999999)
Q_A6_TR1 n87 n85 n69 Qmod_A6_TR1
.model Qmod_A6_TR2 NPN(IS=7.049e-15 BF=677 BR=2.2090000000000001 NF=1 NR=1)
Q_A6_TR2 n81 n87 0 Qmod_A6_TR2
.model Qmod_A6_TR3 NPN(IS=7.049e-15 BF=677 BR=2.2090000000000001 NF=1 NR=1)
Q_A6_TR3 n80 n81 n94 Qmod_A6_TR3
.model Qmod_A6_TR4 PNP(IS=1e-14 BF=250 BR=3 NF=1 NR=1)
Q_A6_TR4 n71 n80 n64 Qmod_A6_TR4
.model Qmod_A6_TR5 NPN(IS=1.43e-14 BF=255.90000000000001 BR=6.0919999999999996 NF=1 NR=1)
Q_A6_TR5 n71 n74 n93 Qmod_A6_TR5
.model Qmod_A4_TR1 PNP(IS=3.8299999999999998e-14 BF=344.39999999999998 BR=14.84 NF=1.008 NR=1.0049999999999999)
Q_A4_TR1 n86 n83 n67 Qmod_A4_TR1
.model Qmod_A4_TR2 NPN(IS=7.049e-15 BF=677 BR=2.2090000000000001 NF=1 NR=1)
Q_A4_TR2 n78 n86 0 Qmod_A4_TR2
.model Qmod_A4_TR3 NPN(IS=7.049e-15 BF=677 BR=2.2090000000000001 NF=1 NR=1)
Q_A4_TR3 n77 n78 n90 Qmod_A4_TR3
.model Qmod_A4_TR4 PNP(IS=1e-14 BF=250 BR=3 NF=1 NR=1)
Q_A4_TR4 n68 n77 n62 Qmod_A4_TR4
.model Qmod_A4_TR5 NPN(IS=1.43e-14 BF=255.90000000000001 BR=6.0919999999999996 NF=1 NR=1)
Q_A4_TR5 n68 n72 n88 Qmod_A4_TR5
.model Qmod_A5_TR1 PNP(IS=3.8299999999999998e-14 BF=344.39999999999998 BR=14.84 NF=1.008 NR=1.0049999999999999)
Q_A5_TR1 n198 n197 n181 Qmod_A5_TR1
.model Qmod_A5_TR2 NPN(IS=7.049e-15 BF=677 BR=2.2090000000000001 NF=1 NR=1)
Q_A5_TR2 n192 n198 0 Qmod_A5_TR2
.model Qmod_A5_TR3 NPN(IS=7.049e-15 BF=677 BR=2.2090000000000001 NF=1 NR=1)
Q_A5_TR3 n191 n192 n204 Qmod_A5_TR3
.model Qmod_A5_TR4 PNP(IS=1e-14 BF=250 BR=3 NF=1 NR=1)
Q_A5_TR4 n182 n191 n176 Qmod_A5_TR4
.model Qmod_A5_TR5 NPN(IS=1.43e-14 BF=255.90000000000001 BR=6.0919999999999996 NF=1 NR=1)
Q_A5_TR5 n182 n186 n203 Qmod_A5_TR5
.model Qmod_A7_TR1 PNP(IS=3.8299999999999998e-14 BF=344.39999999999998 BR=14.84 NF=1.008 NR=1.0049999999999999)
Q_A7_TR1 n201 n199 n183 Qmod_A7_TR1
.model Qmod_A7_TR2 NPN(IS=7.049e-15 BF=677 BR=2.2090000000000001 NF=1 NR=1)
Q_A7_TR2 n195 n201 0 Qmod_A7_TR2
.model Qmod_A7_TR3 NPN(IS=7.049e-15 BF=677 BR=2.2090000000000001 NF=1 NR=1)
Q_A7_TR3 n194 n195 n209 Qmod_A7_TR3
.model Qmod_A7_TR4 PNP(IS=1e-14 BF=250 BR=3 NF=1 NR=1)
Q_A7_TR4 n185 n194 n178 Qmod_A7_TR4
.model Qmod_A7_TR5 NPN(IS=1.43e-14 BF=255.90000000000001 BR=6.0919999999999996 NF=1 NR=1)
Q_A7_TR5 n185 n188 n208 Qmod_A7_TR5

.control
set numdgt=17
ac lin 1 1500 1500
wrdata ac.txt v(out)
quit
.endc
.end
