* LiveWDF netlist exported by SpiceExport (core)
.title LiveWDF
* Engine integrates with trapezoidal at 48000 Hz
.options method=gear maxord=2 reltol=1e-4 abstol=1e-9 vntol=1e-5 chgtol=1e-12 trtol=7
R_R1 in 0 22000000
R_R3 n3 n7 1000
R_R2 n2 n3 10000000
R_R4 n4 n5 56000
R_R5_1 n4 n8 32494.066247839626
R_R5_2 n8 n8 467505.9337521604
R_R6 n8 n9 2700
R_R9 n6 out 470
R_R10 out 0 10000
R_R7 n1 n2 100000
R_R8 n2 0 100000
C_C1 in n3 9.9999999999999995e-08
C_C2 n4 n5 5.0000000000000002e-11
C_C3 n9 0 4.6999999999999999e-06
C_C5 n5 n6 1.5e-05
C_C4 n2 0 9.9999999999999995e-07
V_IN1 in 0 SIN(0 0.10000000000000001 750)
V_VCC n1 0 DC 8.8000000000000007
B_IC1 x_IC1_out 0 V = {min(max(6000*V(n7,n4),1.3),7.5)}
R_IC1_ro x_IC1_out n5 75

.control
set numdgt=17
tran 2.0833333333333333e-05 0.085312499999999999 0 2.6041666666666666e-06
linearize v(out)
wrdata tran.txt v(out)
quit
.endc
.end
