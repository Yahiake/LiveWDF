* LiveWDF netlist exported by SpiceExport (core)
.title LiveWDF
* Engine integrates with trapezoidal at 48000 Hz
.options method=gear maxord=2 reltol=1e-4 abstol=1e-9 vntol=1e-5 chgtol=1e-12 trtol=7
R_R1 in n12 10000
R_R2 n13 n22 470000
R_R3 n15 0 10000
R_R4 n16 n22 100000
R_R5 n3 n4 33000
R_VR1 n4 n5 499500
R_R6 n3 n26 4700
R_R7 n5 n8 10000
R_VR3_1 n6 n1 10000
R_VR3_2 n1 n8 10000
R_R8 n2 0 470
R_R9 n6 n7 10000
R_R10 n17 n18 4700
R_VR2_1 n18 n19 3500
R_VR2_2 n19 n22 6500
R_R11 n19 n20 22000
R_R12 n21 n22 1000000
R_R15 n23 0 10000
R_R16 n23 n24 1000
R_R17 out 0 100000
R_R18 n25 n22 33000
R_R19 n22 0 33000
C_C1 n12 n13 4.6999999999999997e-08
C_C2 n15 n16 1.7999999999999999e-08
C_C3 n26 n22 4.6999999999999997e-08
C_C4 n8 n22 1.7999999999999999e-08
C_C5 n1 n2 2.7e-08
C_C6 n6 n7 1e-08
C_C7 n7 n17 9.9999999999999995e-07
C_C8 n20 n21 4.6999999999999997e-08
C_C10 n24 out 9.9999999999999995e-07
C_C11 n22 0 4.6999999999999997e-05
V_IN1 in 0 SIN(0 0.050000000000000003 750)
V_V_Q5 n9 0 DC 9
V_V_IC1B n10 0 DC 9
V_V_IC1A n11 0 DC 9
V_V_Q6 n14 0 DC 9
V_V_BIAS n25 0 DC 9
B_IC1B x_IC1B_out 0 V = {min(max(100000*V(n16,n3),-12),12)}
R_IC1B_ro x_IC1B_out n5 75
B_IC1A x_IC1A_out 0 V = {min(max(100000*V(n8,n6),-12),12)}
R_IC1A_ro x_IC1A_out n7 75
.model Dmod_D4 D(Is=4.3519999999999999e-09 N=1.9050000000000002 RS=0.56000000000000005)
D_D4 n3 n5 Dmod_D4
Rp_D4 n3 n5 1000000
.model Dmod_D5_D6 D(Is=4.3519999999999999e-09 N=3.8100000000000005 RS=1.1200000000000001)
D_D5_D6 n5 n3 Dmod_D5_D6
Rp_D5_D6 n5 n3 1000000
.model Qmod_Q5 NPN(IS=1e-14 BF=300 BR=4 NF=1 NR=1)
Q_Q5 n9 n13 n15 Qmod_Q5
.model Qmod_Q6 NPN(IS=1e-14 BF=300 BR=4 NF=1 NR=1)
Q_Q6 n14 n21 n23 Qmod_Q6

.control
set numdgt=17
tran 2.0833333333333333e-05 0.085312499999999999 0 2.6041666666666666e-06
linearize v(out)
wrdata tran.txt v(out)
quit
.endc
.end
